Generated circuit netlist (WriteCircuitNetlist from sim_config.txt) -- DO NOT EDIT BY HAND
.INCLUDE sim_params.inc

* === CIRCUIT SIDE (source_kind=0) ===
Bemf s 0 V = { amp_src*sin(2*pi*f_src*time) }

* series R/L/C  source->port
Rs_d s cm0 {Rs}
Ls_d cm0 p {Ls} IC=0

* === WR INTERFACE (fixed): prev waveforms, ammeter, matched-secant Bfield ===
VFprev vfprev 0 PWL FILE "vf_prev_k.pwl"
VIprev iprev  0 PWL FILE "i_prev_k.pwl"
Vmeas p nx 0
Bfield nx 0 V = {
+ V(vfprev) + (Rrom + Lrom/MAX(time - t_abs_start, t_floor)) * (I(Vmeas) - V(iprev))
+ }

.INCLUDE restart.inc
.print tran V(p) V(nx) I(Vmeas)
.end
