WR toy: real-device companion-network coupling (BDF, restart-native) -- PROTOTYPE
.INCLUDE sim_params.inc

* ============================================================================
* PROTOTYPE: field-circuit coupling via a REAL companion-model preconditioner
* plus an iterate-lagged residual source (deferred correction), replacing the
* behavioral accumulated-secant interface. Goal: all reactive elements are real
* Xyce devices (BDF), so Ls carries its current + dI/dt natively across the
* checkpoint/restart window boundary -- no per-window secant reset, no dIdt0.
* ============================================================================

* === Real circuit branch (all BDF, carried natively by checkpoint/restart) ===
* EMF: pure source, ABSOLUTE time (phase comes from the continuous restart time).
Bemf  emf 0  V = { amp_src*sin(2*pi*f_src*time) }
* Series coupling impedance source->port as REAL devices.
Rs_d  emf a  {Rs}
* Ls als echtes Bauteil zwischen a und b (Ls>0 → Induktivitaet IC=0; Ls=0 → winziger
* Widerstands-Kurzschluss statt degeneriertem L=0). Von WriteLsBranch generiert.
.INCLUDE ls_branch.inc
* 0V-Strommesser b->p: Interface-Strom i_Ls = I(Vmeas), unabhaengig vom Ls-Bauteilnamen.
Vmeas b p 0

* === Field ROM as a REAL companion RESISTANCE, IN SERIES with the correction (Thevenin) ===
* WR preconditioner = Rrom only (no Lrom!). The ROM resistor carries the FULL interface
* current i_Ls (p -> Rrom_d -> g). A purely RESISTIVE ROM is deliberate: in the series
* (Thevenin) form i_Ls = (V_p - V_corr)/Z_rom, so a small inductive Z_rom would amplify
* the V_corr discretization slack by 1/Z_rom (measured: an R+L series ROM converges WORSE
* than Norton). With Z_rom = Rrom the closure i_Ls = I_FEM is exact and well-conditioned.
Rrom_d p  g  {Rrom}

* === Lagged FEM correction as a SERIES VOLTAGE source (Thevenin dual of the former
*     parallel current source Bcorr). Much better conditioned for resistive coupling. ===
* V_corr = V_p^(k-1) - Rrom*I_FEM^(k-1)   (= Joerg's dV_field, resistive ROM).
* KVL: V_p = Rrom*i_Ls + V_corr  =>  i_Ls = (V_p - V_corr)/Rrom -> I_FEM at the fixpoint
* (algebraic, no derivative, exact at every coupling node). PWL FILE on absolute time grid.
Vcorr g 0 PWL FILE "vcorr_prev_k.pwl"

* .OPTIONS RESTART und .tran werden pro Zeitfenster vom C++-Master generiert (restart.inc).
.INCLUDE restart.inc
* Ausgaben: Portspannung, Interface-Strom (I(Vmeas)) und Serien-Strom (I(Vcorr) = i_Ls).
.print tran V(p) I(Vmeas) I(Vcorr)
.end
