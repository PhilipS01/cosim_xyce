Toy Problem aus RL glied mit Xyce loesen
.INCLUDE sim_params.inc

* === REAL-Ls RETRY, THEVENIN variant (branch feat/wr-secant-real-ls-thevenin) ===
* Series coupling impedance Rs/Ls are REAL Xyce devices (BDF inductor Ls_d carries its restart
* state NATIVELY across windows — a plain L round-trips through .OPTIONS RESTART).
* The field ROM is the window-anchored matched secant, here in THEVENIN form: a behavioral
* VOLTAGE source Bfield (the dual of the Norton current source Biface on feat/wr-secant-real-ls).
* Motivation: a voltage source in series with a real inductor is the WELL-POSED pairing (no
* degenerate current-source-in-series-with-L). Dual caveat: Z_rom -> inf at the window start
* (t_acc->0, open circuit) -> the MAX(.,t_floor) floor is LOAD-BEARING here (neutral for Norton).
*
* Topology (single series loop):  s --Rs_d--> m --Ls_d--> p --Vmeas--> nx --Bfield--> 0
* Bemf = pure EMF (no series drop folded in). V(p) now develops across the real Rs_d/Ls_d.

Bemf s 0 V = { amp_src*sin(2*pi*f_src*time) }

Rs_d  s m  {Rs}
Ls_d  m p  {Ls} IC=0

* Alte Feld-/Interface-Waveforms aus WR-Iteration k
VFprev vfprev   0 PWL FILE "vf_prev_k.pwl"
VIprev iprev    0 PWL FILE "i_prev_k.pwl"

* Nullvoltquelle zur Strommessung des aktuellen Interface-Stroms
Vmeas p nx 0

* Interface-Bedingung — THEVENIN, EXPLIZITE Transmissionsbedingung (Spannungsquelle).
* Wortwoertlich die Transmission V_C^{k+1} = R*I_C^{k+1} + L*(I_C^{k+1}-I_C^{k+1}(t0))/tau
*                                  + V_F^k - ( R*I_F^k + L*(I_F^k-I_F^k(t0))/tau ),  tau = t-t0.
* I_C^{k+1}(t)=I(Vmeas) (absoluter Schaltungsstrom dieser Iteration), I_F^k(t)=V(iprev) (gelaggter
* Feldstrom), V_F^k=V(vfprev). Fenster-Start-Anker I_C(t0)=I_F(t0)=I0 (Restart/Vorfenster-Ende).
* WICHTIG: R*I(Vmeas) ist der ABSOLUTE resistive Drop (kein Strom-Differenz-Term); die Sekanten
* sind an I0 verankert. Algebraisch faellt I0 zur kompakten Form (R+L/tau)(I_C-I_F) zusammen
* (da beide Anker = I0), aber explizit ist es die dokumentierte Bedingung und robust, falls die
* Fenster-Start-Stroeme je Seite je auseinanderlaufen.
Bfield nx 0 V = {
+ Rrom*I(Vmeas) + Lrom*(I(Vmeas) - I0)/MAX(time - t_abs_start, t_floor)
+ + V(vfprev) - ( Rrom*V(iprev) + Lrom*(V(iprev) - I0)/MAX(time - t_abs_start, t_floor) )
+ }

* .OPTIONS RESTART und .tran werden pro Zeitfenster vom C++-Master generiert
* (Fenster 1: UIC-Transient ab 0; Fenster k>1: Restart ab Checkpoint). Siehe WriteRestartDirectives.
.INCLUDE restart.inc
.print tran V(p) V(nx) I(Vmeas)
.end
