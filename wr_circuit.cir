WR toy: real-device companion-network coupling (BDF, restart-native) -- PROTOTYPE
.INCLUDE sim_params.inc

* ============================================================================
* PROTOTYPE: field-circuit coupling via a REAL companion-model preconditioner
* plus an iterate-lagged residual source (deferred correction), replacing the
* behavioral accumulated-secant interface. Goal: all reactive elements are real
* Xyce devices (BDF), so Ls carries its current + dI/dt natively across the
* checkpoint/restart window boundary -- no per-window secant reset, no dIdt0.
* ============================================================================

* === Real circuit branch (all BDF, carried natively by checkpoint/restart) ===
* EMF: pure source, ABSOLUTE time (phase comes from the continuous restart time).
Bemf  emf 0  V = { amp_src*sin(2*pi*f_src*time) }
* Series coupling impedance source->port as REAL devices.
Rs_d  emf a  {Rs}
* Ls als echtes Bauteil zwischen a und b (Ls>0 → Induktivitaet IC=0; Ls=0 → winziger
* Widerstands-Kurzschluss statt degeneriertem L=0). Von WriteLsBranch generiert.
.INCLUDE ls_branch.inc
* 0V-Strommesser b->p: Interface-Strom i_Ls = I(Vmeas), unabhaengig vom Ls-Bauteilnamen.
Vmeas b p 0

* === Field ROM as a REAL companion R-L branch: port p -> ground ===
* This is the WR preconditioner (Norton admittance 1/(Rrom + s*Lrom)), now
* BDF-integrated so it is consistent with the real Ls inductor. It cancels out
* at the WR fixpoint (only sets the convergence rate, not the answer).
Rrom_d p  m  {Rrom}
Lrom_d m  0  {Lrom} IC=0

* === Lagged FEM correction (deferred-correction Norton source) ===
* icorr = I_FEM^(k-1) - i_rom^(k-1), supplied on an isolated reference node via a
* PWL-FILE source (absolute time grid). Bcorr injects it as a current p->0, so the
* interface current  i_Ls = i_rom + icorr  ->  I_FEM  at convergence.
Vcorr icorr 0 PWL FILE "icorr_prev_k.pwl"
Bcorr p 0 I = { V(icorr) }

* .OPTIONS RESTART und .tran werden pro Zeitfenster vom C++-Master generiert (restart.inc).
.INCLUDE restart.inc
* Ausgaben: Portspannung, Interface-Strom (I(Vmeas)) und ROM-Zweigstrom (I(Lrom_d)).
.print tran V(p) I(Vmeas) I(Lrom_d)
.end
