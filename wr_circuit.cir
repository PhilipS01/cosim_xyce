Toy Problem aus RL glied mit Xyce loesen
.INCLUDE sim_params.inc

* === REAL-Ls RETRY (branch feat/wr-secant-real-ls) ===
* Series coupling impedance Rs/Ls are now REAL Xyce devices (BDF inductor Ls_d carries its
* restart state NATIVELY across windows — a plain L round-trips through .OPTIONS RESTART),
* instead of being folded into the behavioral matched-secant source Bsrc.
* The field ROM Biface stays the window-anchored matched secant. This is exactly the
* combo the notes flagged as incompatible (continuous BDF Ls vs resetting secant ROM);
* retrying with the carried dIdt0 seed (i_prev_k.pwl ramp slope) to bridge the boundary.
*
* Topology (single series loop):  s --Rs_d--> m --Ls_d--> p --Vmeas--> nx --Biface--> 0
* Bemf = pure EMF (no series drop folded in). V(p) now develops across the real Rs_d/Ls_d.

Bemf s 0 V = { amp_src*sin(2*pi*f_src*time) }

Rs_d  s m  {Rs}
Ls_d  m p  {Ls} IC=0

* Alte Feld-/Interface-Waveforms aus WR-Iteration k
VFprev vfprev   0 PWL FILE "vf_prev_k.pwl"
VIprev iprev    0 PWL FILE "i_prev_k.pwl"

* Nullvoltquelle zur Strommessung des aktuellen Interface-Stroms
Vmeas p nx 0

* Akkumulierte Interface-Bedingung (Strom-Quelle, voltage-driven FEM) — unveraendert.
* I(Vmeas) = I_field_prev + (V(p) - V(vfprev)) / (Rrom + Lrom/t_acc)
Biface nx 0 I = {
+ V(iprev) + (V(p) - V(vfprev)) / (Rrom + Lrom/MAX(time - t_abs_start, t_floor))
+ }

* .OPTIONS RESTART und .tran werden pro Zeitfenster vom C++-Master generiert
* (Fenster 1: UIC-Transient ab 0; Fenster k>1: Restart ab Checkpoint). Siehe WriteRestartDirectives.
.INCLUDE restart.inc
.print tran V(p) V(nx) I(Vmeas)
.end
