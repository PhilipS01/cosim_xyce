Toy Problem aus RL glied mit Xyce loesen
.INCLUDE sim_params.inc

* === REAL-Ls RETRY, THEVENIN + R-SPLIT (branch feat/wr-secant-real-rrom) ===
* Series coupling Rs/Ls are REAL Xyce devices (BDF inductor Ls_d carries its restart state
* natively across windows). Field ROM = window-anchored matched secant in THEVENIN form.
* R-SPLIT: the ROM resistance Rrom is pulled out as a REAL series resistor Rrom_d (absolute
* drop Rrom*I_C, implicit in Xyce), leaving Bfield to carry only the inductive secant + the
* deferred field correction. RESULT: bit-identical WR iteration count to the lumped behavioral
* Bfield (Ls 1.6e-7: 205 total/max 11; Ls 1e-6: max 18) -- because the behavioral Bfield
* ALREADY exposes d(Bfield)/dI(Vmeas)=Rrom to Xyce's Newton, so a real Rrom_d adds nothing.
*
* Topology (single series loop): s --Rs_d--> m --Ls_d--> p --Vmeas--> nx --Rrom_d--> g --Bfield--> 0
* Bemf = pure EMF (no series drop folded in). V(p) now develops across the real Rs_d/Ls_d.

Bemf s 0 V = { amp_src*sin(2*pi*f_src*(time + t_phase)) }

Rs_d  s m  {Rs}
Ls_d  m p  {Ls} IC=0

* Alte Feld-/Interface-Waveforms aus WR-Iteration k
VFprev vfprev   0 PWL FILE "vf_prev_k.pwl"
VIprev iprev    0 PWL FILE "i_prev_k.pwl"

* Nullvoltquelle zur Strommessung des aktuellen Interface-Stroms
Vmeas p nx 0

* R-SPLIT (Branch feat/wr-secant-real-rrom): Rrom als ECHTES Reihen-Widerstandsdevice
* (absoluter Drop Rrom*I_C, NICHT gelaggt). Bfield traegt nur noch den induktiven
* Sekanten-Anteil + die deferred Feld-Korrektur. Aus der expliziten Transmission
*   V_p = Rrom*I_C + Lrom*(I_C-I0)/tau + V_F - Rrom*I_F - Lrom*(I_F-I0)/tau
* wird Rrom*I_C zum Device Rrom_d; der Rest (Bfield) kollabiert (I0 hebt sich) zu
*   Bfield = V_F - Rrom*I_F + Lrom/tau*(I_C - I_F).
* Test: senkt der reale (implizite) R-Drop die WR-Iterationszahl ggue. der gelumpten Form?
Rrom_d nx g {Rrom}
Bfield g 0 V = {
+ V(vfprev) - Rrom*V(iprev) + Lrom/MAX(time - t_abs_start, t_floor) * (I(Vmeas) - V(iprev))
+ }

* .OPTIONS RESTART und .tran werden pro Zeitfenster vom C++-Master generiert
* (Fenster 1: UIC-Transient ab 0; Fenster k>1: Restart ab Checkpoint). Siehe WriteRestartDirectives.
.INCLUDE restart.inc
.print tran V(p) V(nx) I(Vmeas)
.end
