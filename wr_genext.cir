WR GenExt skeleton: field as a YGENEXT device (implicit coupling)
* Circuit branch: EMF source -> Rs -> port p. Field ROM is the YGENEXT device
* "field" between port p and ground (a series R-L surrogate, loaded by GenExtDriver
* via computeXyceVectors). Vmeas measures the interface current i_Ls = I(Vmeas).
Bemf  emf 0  V = { sin(2*3.14159265358979*50*time) }
Rs_d  emf a  6e-3
Vmeas a  p   0
* Field ROM device: 2 terminals (port p, ground). Loaded by the driver (R-L + Q=L*i).
YGENEXT field p 0
.tran 4e-6 0.02 0 UIC
.print tran V(p) I(Vmeas)
.end
