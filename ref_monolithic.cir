Monolithic RL reference
Vsrc s 0 SIN(0 1 50)
Rs s m 0.006
Ls m p 1.6e-07
Rf p n 0.00051
Lf n 0 1.6e-07
.tran 1e-7 0.02
.print tran I(Lf) V(p)
.end
